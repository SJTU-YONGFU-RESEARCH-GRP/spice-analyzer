* Minimal sky130 tt for ngspice: define l/w/mult globals so BSIM
* curly-brace model expressions can parse (open_pdks normally patches these).
.option scale=1.0u
.param l=1 w=1 mult=1 nf=1 ad=0 as=0 pd=0 ps=0 nrd=0 nrs=0 sa=0 sb=0 sd=0
* Corner diffs then models (tt.corner ends with .include of tt.pm3)
.include "../../../models/pdk/sky130_fd_pr/cells/nfet_01v8/sky130_fd_pr__nfet_01v8__mismatch.corner.spice"
.include "../../../models/pdk/sky130_fd_pr/cells/pfet_01v8/sky130_fd_pr__pfet_01v8__mismatch.corner.spice"
.include "../../../models/pdk/sky130_fd_pr/cells/nfet_01v8/sky130_fd_pr__nfet_01v8__tt.corner.spice"
.include "../../../models/pdk/sky130_fd_pr/cells/pfet_01v8/sky130_fd_pr__pfet_01v8__tt.corner.spice"
* Provide LOD diffs referenced by model cards if missing
.param sky130_fd_pr__nfet_01v8__wlod_diff=0
+ sky130_fd_pr__nfet_01v8__kvth0_diff=0
+ sky130_fd_pr__nfet_01v8__lkvth0_diff=0
+ sky130_fd_pr__nfet_01v8__wkvth0_diff=0
+ sky130_fd_pr__nfet_01v8__ku0_diff=0
+ sky130_fd_pr__nfet_01v8__lku0_diff=0
+ sky130_fd_pr__nfet_01v8__wku0_diff=0
+ sky130_fd_pr__nfet_01v8__kvsat_diff=0
+ sky130_fd_pr__pfet_01v8__wlod_diff=0
+ sky130_fd_pr__pfet_01v8__kvth0_diff=0
+ sky130_fd_pr__pfet_01v8__lkvth0_diff=0
+ sky130_fd_pr__pfet_01v8__wkvth0_diff=0
+ sky130_fd_pr__pfet_01v8__ku0_diff=0
+ sky130_fd_pr__pfet_01v8__lku0_diff=0
+ sky130_fd_pr__pfet_01v8__wku0_diff=0
+ sky130_fd_pr__pfet_01v8__kvsat_diff=0
