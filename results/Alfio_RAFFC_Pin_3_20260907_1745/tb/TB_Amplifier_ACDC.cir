Test OpAmp ACDC — Alfio_RAFFC_Pin_3 (adapted from AnalogGym)

***************************************
* Netlist + sizing (snapshots under results/.../tb/)
***************************************
.include Alfio_RAFFC_Pin_3
.include Alfio_RAFFC_Pin_3.params

.param mc_mm_switch=0
.param mc_pr_switch=0

.include sky130_tt_01v8.spice

.PARAM supply_voltage = 1.8
* Design-vars VCM=300m → ratio 300m/1.8
.PARAM VCM_ratio = 0.1666667
* Prefer design CLOAD=100p over TB default 500p
.PARAM PARAM_CLOAD = 'CLOAD'

V1 vdd 0 'supply_voltage'
V2 vss 0 0

Vindc opin 0 'supply_voltage*VCM_ratio'
Vin signal_in 0 dc 'supply_voltage*VCM_ratio' ac 1

Lfb opout opout_dc 1T
Cin opout_dc signal_in 1T

***************************************
* XOP: gnda vdda vinn vinp vout
***************************************
*    ADM TB
Xop1 vss vdd opout_dc opin opout  alfio_raffc_pin_3
Cload1 opout 0 'PARAM_CLOAD'

*   ACM TB
xop2 vss vdd cm2 cm1 cm3  alfio_raffc_pin_3
Cload2 cm3 0 'PARAM_CLOAD'
vcmdc cm0 0 'supply_voltage*VCM_ratio'
vcmac1 cm1 cm0 0 ac=1
vcmac2 cm2 cm3 0 ac=1
.meas ac cmrrdc find vdb(cm3) at = 0.1
.meas ac dcgain find vdb(opout) at = 0.1
.meas ac gain_bandwidth_product when vdb(opout)=0
.meas ac phase_in_rad find vp(opout) when vdb(opout)=0
.meas ac phase_in_deg param='phase_in_rad*180/3.1416'

* PSRR TB
VGNDApsrr gndpsrr 0 0 AC=1
VVDDApsrr vddpsrr 0 'supply_voltage' AC=1
xop3 vss vddpsrr ppsr1 opin ppsr1  alfio_raffc_pin_3
Cload3 ppsr1 0 'PARAM_CLOAD'
xop4 gndpsrr vdd npsr1 opin npsr1  alfio_raffc_pin_3
Cload4 npsr1 0 'PARAM_CLOAD'
.measure ac DCPSRp find vdb(ppsr1) at = 0.1
.measure ac DCPSRn find vdb(npsr1) at = 0.1

* DC TB (power / Vos at 25C; coarse TC)
VVDDdc VDDdc 0 'supply_voltage'
xop5 vss vdddc vout6 opin vout6  alfio_raffc_pin_3
Cload5 vout6 0 'PARAM_CLOAD'
.measure dc maxval MAX V(vout6) from=-40 to=125
.measure dc minval MIN V(vout6) from=-40 to=125
.measure dc avgval AVG V(vout6) from=-40 to=125
.measure dc ppavl  PP V(vout6) from=-40 to=125
.measure dc TC param='ppavl/avgval/165'
.meas dc Ivdd25 FIND I(VVDDDC) AT=25
.meas dc Power param='-1*Ivdd25*supply_voltage'
.meas dc vout25 FIND V(vout6) AT=25
.meas dc vos25 param = 'vout25-supply_voltage*VCM_ratio'

.control
set noaskquit
option numdgt=6
* Coarse temp sweep (AnalogGym uses 0.1; coarsened for runtime)
DC temp -40 125 5
ac dec 20 0.1 1G
* Export AC vectors for Bode plots
wrdata ../figures/bode_mag.dat vdb(opout)
wrdata ../figures/bode_phase.dat vp(opout)
echo MEASURES_BEGIN
print dcgain gain_bandwidth_product phase_in_deg cmrrdc DCPSRp DCPSRn Power vos25 TC
echo MEASURES_END
.endc

.end
