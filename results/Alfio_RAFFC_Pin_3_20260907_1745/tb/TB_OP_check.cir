* Quick OP check for Alfio_RAFFC_Pin_3
.include Alfio_RAFFC_Pin_3
.include Alfio_RAFFC_Pin_3.params
.include sky130_tt_01v8.spice

.PARAM supply_voltage = 1.8
.PARAM VCM = 0.9
.PARAM PARAM_CLOAD = 'CLOAD'

Vdd vdd 0 'supply_voltage'
Vss vss 0 0
Vinp vinp 0 'VCM'
Vinn vinn 0 'VCM'
Xop vss vdd vinn vinp vout alfio_raffc_pin_3
Cload vout 0 'PARAM_CLOAD'

.control
set noaskquit
op
print v(vout) v(xop.net050) v(xop.net013) v(xop.net043) v(xop.net063)
print v(xop.net1) v(xop.vb3) v(xop.vb4) v(xop.net31) v(xop.voutn)
print i(vdd)
* Try AC open-loop-ish with unity-gain DC FB
.endc
.end
