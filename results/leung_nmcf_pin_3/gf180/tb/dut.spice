* leung_nmcf_pin_3 — GF180 3.3V (fold M into W; SCALE_WM)
* Pins: gnda vdda vinn vinp vout
.subckt leung_nmcf_pin_3 gnda vdda vinn vinp vout
XM11 VOUT net050 VDDA VDDA pmos_3p3 l='MOSFET_11_1_L_gmf2_PMOS*1u' w='MOSFET_11_1_W_gmf2_PMOS*MOSFET_11_1_M_gmf2_PMOS*SCALE_WM*1u'
XM7  net049 net013 VDDA VDDA pmos_3p3 l='MOSFET_0_8_L_BIASCM_PMOS*1u' w='MOSFET_0_8_W_BIASCM_PMOS*MOSFET_0_8_M_BIASCM_PMOS*SCALE_WM*1u'
XM10 net043 net050 VDDA VDDA pmos_3p3 l='MOSFET_10_1_L_gm2_PMOS*1u' w='MOSFET_10_1_W_gm2_PMOS*MOSFET_10_1_M_gm2_PMOS*SCALE_WM*1u'
XM6  net050 VOUTN VDDA VDDA pmos_3p3 l='MOSFET_0_8_L_BIASCM_PMOS*1u' w='MOSFET_0_8_W_BIASCM_PMOS*MOSFET_0_8_M_BIASCM_PMOS*SCALE_WM*1u'
XM5  VOUTN VOUTN VDDA VDDA pmos_3p3 l='MOSFET_0_8_L_BIASCM_PMOS*1u' w='MOSFET_0_8_W_BIASCM_PMOS*MOSFET_0_8_M_BIASCM_PMOS*SCALE_WM*1u'
XM9  net063 VINP net31 net31 pmos_3p3 l='MOSFET_8_2_L_gm1_PMOS*1u' w='MOSFET_8_2_W_gm1_PMOS*MOSFET_8_2_M_gm1_PMOS*SCALE_WM*1u'
XM8  DM_2 VINN net31 net31 pmos_3p3 l='MOSFET_8_2_L_gm1_PMOS*1u' w='MOSFET_8_2_W_gm1_PMOS*MOSFET_8_2_M_gm1_PMOS*SCALE_WM*1u'
XM4  net31 net013 VDDA VDDA pmos_3p3 l='MOSFET_0_8_L_BIASCM_PMOS*1u' w='MOSFET_0_8_W_BIASCM_PMOS*4*MOSFET_0_8_M_BIASCM_PMOS*SCALE_WM*1u'
XM3  VB3 net013 VDDA VDDA pmos_3p3 l='MOSFET_0_8_L_BIASCM_PMOS*1u' w='MOSFET_0_8_W_BIASCM_PMOS*MOSFET_0_8_M_BIASCM_PMOS*SCALE_WM*1u'
XM2  DM_1 net013 VDDA VDDA pmos_3p3 l='MOSFET_0_8_L_BIASCM_PMOS*1u' w='MOSFET_0_8_W_BIASCM_PMOS*MOSFET_0_8_M_BIASCM_PMOS*SCALE_WM*1u'
XM1  VB4 net013 VDDA VDDA pmos_3p3 l='MOSFET_0_8_L_BIASCM_PMOS*1u' w='MOSFET_0_8_W_BIASCM_PMOS*MOSFET_0_8_M_BIASCM_PMOS*SCALE_WM*1u'
XM0  net013 net013 VDDA VDDA pmos_3p3 l='MOSFET_0_8_L_BIASCM_PMOS*1u' w='MOSFET_0_8_W_BIASCM_PMOS*MOSFET_0_8_M_BIASCM_PMOS*SCALE_WM*1u'
XM14 VB3 VB3 GNDA GNDA nmos_3p3 l='MOSFET_17_7_L_BIASCM_NMOS*1u' w='MOSFET_17_7_W_BIASCM_NMOS*MOSFET_17_7_M_BIASCM_NMOS*SCALE_WM*1u'
XM23 VOUT net049 GNDA GNDA nmos_3p3 l='MOSFET_23_1_L_gm3_NMOS*1u' w='MOSFET_23_1_W_gm3_NMOS*MOSFET_23_1_M_gm3_NMOS*SCALE_WM*1u'
XM22 net049 net043 GNDA GNDA nmos_3p3 l='MOSFET_21_2_L_LOAD2_NMOS*1u' w='MOSFET_21_2_W_LOAD2_NMOS*MOSFET_21_2_M_LOAD2_NMOS*SCALE_WM*1u'
XM21 net043 net043 GNDA GNDA nmos_3p3 l='MOSFET_21_2_L_LOAD2_NMOS*1u' w='MOSFET_21_2_W_LOAD2_NMOS*MOSFET_21_2_M_LOAD2_NMOS*SCALE_WM*1u'
XM19 DM_2 VB4 GNDA GNDA nmos_3p3 l='MOSFET_17_7_L_BIASCM_NMOS*1u' w='MOSFET_17_7_W_BIASCM_NMOS*8*MOSFET_17_7_M_BIASCM_NMOS*SCALE_WM*1u'
XM15 VOUTN VB3 DM_2 GNDA nmos_3p3 l='MOSFET_17_7_L_BIASCM_NMOS*1u' w='MOSFET_17_7_W_BIASCM_NMOS*4*MOSFET_17_7_M_BIASCM_NMOS*SCALE_WM*1u'
XM20 net063 VB4 GNDA GNDA nmos_3p3 l='MOSFET_17_7_L_BIASCM_NMOS*1u' w='MOSFET_17_7_W_BIASCM_NMOS*8*MOSFET_17_7_M_BIASCM_NMOS*SCALE_WM*1u'
XM16 net050 VB3 net063 GNDA nmos_3p3 l='MOSFET_17_7_L_BIASCM_NMOS*1u' w='MOSFET_17_7_W_BIASCM_NMOS*4*MOSFET_17_7_M_BIASCM_NMOS*SCALE_WM*1u'
XM17 net54 VB4 GNDA GNDA nmos_3p3 l='MOSFET_17_7_L_BIASCM_NMOS*1u' w='MOSFET_17_7_W_BIASCM_NMOS*4*MOSFET_17_7_M_BIASCM_NMOS*SCALE_WM*1u'
XM12 VB4 VB3 net54 GNDA nmos_3p3 l='MOSFET_17_7_L_BIASCM_NMOS*1u' w='MOSFET_17_7_W_BIASCM_NMOS*4*MOSFET_17_7_M_BIASCM_NMOS*SCALE_WM*1u'
XM18 net56 VB4 GNDA GNDA nmos_3p3 l='MOSFET_17_7_L_BIASCM_NMOS*1u' w='MOSFET_17_7_W_BIASCM_NMOS*4*MOSFET_17_7_M_BIASCM_NMOS*SCALE_WM*1u'
XM13 DM_1 VB3 net56 GNDA nmos_3p3 l='MOSFET_17_7_L_BIASCM_NMOS*1u' w='MOSFET_17_7_W_BIASCM_NMOS*4*MOSFET_17_7_M_BIASCM_NMOS*SCALE_WM*1u'
I0 net013 GNDA 'CURRENT_0_BIAS'
C1 net049 VOUT 'CAPACITOR_1'
C0 net050 VOUT 'CAPACITOR_0'
.ends leung_nmcf_pin_3
