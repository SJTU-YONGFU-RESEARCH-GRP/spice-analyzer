* IHP SG13G2 LV — recovery iter1: raise C0 for PM (from sky130 sizes, meters)
.param
+ MOSFET_0_8_L_BIASCM_PMOS=1.0u MOSFET_0_8_W_BIASCM_PMOS=1.0u
+ MOSFET_0_8_M_BIASCM_PMOS=7
+ MOSFET_8_2_L_gm1_PMOS=0.52u MOSFET_8_2_W_gm1_PMOS=8.7u
+ MOSFET_8_2_M_gm1_PMOS=6
+ MOSFET_10_1_L_gm2_PMOS=2.05u MOSFET_10_1_W_gm2_PMOS=3.0u
+ MOSFET_10_1_M_gm2_PMOS=27
+ MOSFET_11_1_L_gmf2_PMOS=0.67u MOSFET_11_1_W_gmf2_PMOS=1.45u
+ MOSFET_11_1_M_gmf2_PMOS=40
+ MOSFET_17_7_L_BIASCM_NMOS=0.59u MOSFET_17_7_W_BIASCM_NMOS=1.56u
+ MOSFET_17_7_M_BIASCM_NMOS=1
+ MOSFET_21_2_L_LOAD2_NMOS=0.65u MOSFET_21_2_W_LOAD2_NMOS=7.4u
+ MOSFET_21_2_M_LOAD2_NMOS=21
+ MOSFET_23_1_L_gm3_NMOS=3.58u MOSFET_23_1_W_gm3_NMOS=9.8u
+ MOSFET_23_1_M_gm3_NMOS=17
+ CAPACITOR_0=80p CAPACITOR_1=2p CURRENT_0_BIAS=10u
+ CLOAD=50p VCM=0.6 VDD=1.2
