* IHP OP probe — leung_nmcf_pin_3
.title leung_nmcf_pin_3 ihp mos_tt OP probe

.lib "../../../../models/pdk/ihp-sg13g2/ihp-sg13g2/libs.tech/ngspice/models/cornerMOSlv.lib" mos_tt

.include ./params.spice
.include ./dut.spice

.param supply_voltage={VDD}
.param vcm_val={VCM}

Vdd vdd 0 {supply_voltage}
Vss vss 0 0
Vindc opin 0 {vcm_val}
Vin  signal_in 0 dc {vcm_val} ac 1
Lfb opout opout_dc 1T
Cin opout_dc signal_in 1T
X1 vss vdd opout_dc opin opout leung_nmcf_pin_3
Cload1 opout 0 {CLOAD}

.control
set filetype=ascii
option savecurrents
op
print v(opout) v(opout_dc)
print i(vdd)
echo SHOW_BEGIN
show n.x1.xm8.nsg13_lv_pmos : all
show n.x1.xm10.nsg13_lv_pmos : all
show n.x1.xm23.nsg13_lv_nmos : all
show n.x1.xm11.nsg13_lv_pmos : all
echo SHOW_END
.endc
.end
