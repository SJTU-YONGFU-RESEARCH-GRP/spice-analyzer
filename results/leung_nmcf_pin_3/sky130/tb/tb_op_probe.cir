.title op probe
.option scale=1.0u
.param mc_mm_switch=0 mc_pr_switch=0
.include ../../../../models/pdk/sky130_fd_pr/models/parameters/lod.spice
.include ../../../../models/pdk/sky130_fd_pr/cells/nfet_01v8/sky130_fd_pr__nfet_01v8__mismatch.corner.spice
.include ../../../../models/pdk/sky130_fd_pr/cells/pfet_01v8/sky130_fd_pr__pfet_01v8__mismatch.corner.spice
.include ../../../../models/pdk/sky130_fd_pr/cells/nfet_01v8/sky130_fd_pr__nfet_01v8__tt.pm3.spice
.include ../../../../models/pdk/sky130_fd_pr/cells/pfet_01v8/sky130_fd_pr__pfet_01v8__tt.pm3.spice
.include ./params.spice
.include ./dut.spice
.param supply_voltage={VDD} vcm_val={VCM}
Vdd vdd 0 {supply_voltage}
Vss vss 0 0
Vindc opin 0 {vcm_val}
Vin signal_in 0 dc {vcm_val} ac 1
Lfb opout opout_dc 1T
Cin opout_dc signal_in 1T
X1 vss vdd opout_dc opin opout leung_nmcf_pin_3
Cload1 opout 0 {CLOAD}
.control
op
foreach dev xm8 xm9 xm10 xm11 xm23 xm22 xm21 xm6 xm7 xm16 xm20 xm15 xm0 xm4 xm5
  echo DEV $dev
  print @m.x1.{$dev}.msky130_fd_pr__pfet_01v8[id] @m.x1.{$dev}.msky130_fd_pr__pfet_01v8[gm] @m.x1.{$dev}.msky130_fd_pr__pfet_01v8[gds]
  print @m.x1.{$dev}.msky130_fd_pr__nfet_01v8[id] @m.x1.{$dev}.msky130_fd_pr__nfet_01v8[gm] @m.x1.{$dev}.msky130_fd_pr__nfet_01v8[gds]
end
print v(opout) v(x1.net050) v(x1.net049) v(x1.net043) v(x1.net013)
print -i(vdd)
.endc
.end
