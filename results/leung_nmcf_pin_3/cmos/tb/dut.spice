* leung_nmcf_pin_3 — educational CMOS Level-1 remap (pmos_rvt / nmos_rvt)
* Pins: gnda vdda vinn vinp vout
* Topology: three-stage NMCF (nested Miller + feedforward)
.subckt leung_nmcf_pin_3 gnda vdda vinn vinp vout
* --- FF / stage2 / bias PMOS ---
M11 VOUT net050 VDDA VDDA pmos_rvt l={MOSFET_11_1_L_gmf2_PMOS} w={MOSFET_11_1_W_gmf2_PMOS} m={MOSFET_11_1_M_gmf2_PMOS}
M7  net049 net013 VDDA VDDA pmos_rvt l={MOSFET_0_8_L_BIASCM_PMOS} w={MOSFET_0_8_W_BIASCM_PMOS} m={MOSFET_0_8_M_BIASCM_PMOS}
M10 net043 net050 VDDA VDDA pmos_rvt l={MOSFET_10_1_L_gm2_PMOS} w={MOSFET_10_1_W_gm2_PMOS} m={MOSFET_10_1_M_gm2_PMOS}
M6  net050 VOUTN VDDA VDDA pmos_rvt l={MOSFET_0_8_L_BIASCM_PMOS} w={MOSFET_0_8_W_BIASCM_PMOS} m={MOSFET_0_8_M_BIASCM_PMOS}
M5  VOUTN VOUTN VDDA VDDA pmos_rvt l={MOSFET_0_8_L_BIASCM_PMOS} w={MOSFET_0_8_W_BIASCM_PMOS} m={MOSFET_0_8_M_BIASCM_PMOS}
* --- PMOS input pair + tail / bias ---
M9  net063 VINP net31 net31 pmos_rvt l={MOSFET_8_2_L_gm1_PMOS} w={MOSFET_8_2_W_gm1_PMOS} m={MOSFET_8_2_M_gm1_PMOS}
M8  DM_2 VINN net31 net31 pmos_rvt l={MOSFET_8_2_L_gm1_PMOS} w={MOSFET_8_2_W_gm1_PMOS} m={MOSFET_8_2_M_gm1_PMOS}
M4  net31 net013 VDDA VDDA pmos_rvt l={MOSFET_0_8_L_BIASCM_PMOS} w={MOSFET_0_8_W_BIASCM_PMOS} m={4*MOSFET_0_8_M_BIASCM_PMOS}
M3  VB3 net013 VDDA VDDA pmos_rvt l={MOSFET_0_8_L_BIASCM_PMOS} w={MOSFET_0_8_W_BIASCM_PMOS} m={MOSFET_0_8_M_BIASCM_PMOS}
M2  DM_1 net013 VDDA VDDA pmos_rvt l={MOSFET_0_8_L_BIASCM_PMOS} w={MOSFET_0_8_W_BIASCM_PMOS} m={MOSFET_0_8_M_BIASCM_PMOS}
M1  VB4 net013 VDDA VDDA pmos_rvt l={MOSFET_0_8_L_BIASCM_PMOS} w={MOSFET_0_8_W_BIASCM_PMOS} m={MOSFET_0_8_M_BIASCM_PMOS}
M0  net013 net013 VDDA VDDA pmos_rvt l={MOSFET_0_8_L_BIASCM_PMOS} w={MOSFET_0_8_W_BIASCM_PMOS} m={MOSFET_0_8_M_BIASCM_PMOS}
* --- NMOS bias / cascode / stage2-3 ---
M14 VB3 VB3 GNDA GNDA nmos_rvt l={MOSFET_17_7_L_BIASCM_NMOS} w={MOSFET_17_7_W_BIASCM_NMOS} m={MOSFET_17_7_M_BIASCM_NMOS}
M23 VOUT net049 GNDA GNDA nmos_rvt l={MOSFET_23_1_L_gm3_NMOS} w={MOSFET_23_1_W_gm3_NMOS} m={MOSFET_23_1_M_gm3_NMOS}
M22 net049 net043 GNDA GNDA nmos_rvt l={MOSFET_21_2_L_LOAD2_NMOS} w={MOSFET_21_2_W_LOAD2_NMOS} m={MOSFET_21_2_M_LOAD2_NMOS}
M21 net043 net043 GNDA GNDA nmos_rvt l={MOSFET_21_2_L_LOAD2_NMOS} w={MOSFET_21_2_W_LOAD2_NMOS} m={MOSFET_21_2_M_LOAD2_NMOS}
M19 DM_2 VB4 GNDA GNDA nmos_rvt l={MOSFET_17_7_L_BIASCM_NMOS} w={MOSFET_17_7_W_BIASCM_NMOS} m={8*MOSFET_17_7_M_BIASCM_NMOS}
M15 VOUTN VB3 DM_2 GNDA nmos_rvt l={MOSFET_17_7_L_BIASCM_NMOS} w={MOSFET_17_7_W_BIASCM_NMOS} m={4*MOSFET_17_7_M_BIASCM_NMOS}
M20 net063 VB4 GNDA GNDA nmos_rvt l={MOSFET_17_7_L_BIASCM_NMOS} w={MOSFET_17_7_W_BIASCM_NMOS} m={8*MOSFET_17_7_M_BIASCM_NMOS}
M16 net050 VB3 net063 GNDA nmos_rvt l={MOSFET_17_7_L_BIASCM_NMOS} w={MOSFET_17_7_W_BIASCM_NMOS} m={4*MOSFET_17_7_M_BIASCM_NMOS}
M17 net54 VB4 GNDA GNDA nmos_rvt l={MOSFET_17_7_L_BIASCM_NMOS} w={MOSFET_17_7_W_BIASCM_NMOS} m={4*MOSFET_17_7_M_BIASCM_NMOS}
M12 VB4 VB3 net54 GNDA nmos_rvt l={MOSFET_17_7_L_BIASCM_NMOS} w={MOSFET_17_7_W_BIASCM_NMOS} m={4*MOSFET_17_7_M_BIASCM_NMOS}
M18 net56 VB4 GNDA GNDA nmos_rvt l={MOSFET_17_7_L_BIASCM_NMOS} w={MOSFET_17_7_W_BIASCM_NMOS} m={4*MOSFET_17_7_M_BIASCM_NMOS}
M13 DM_1 VB3 net56 GNDA nmos_rvt l={MOSFET_17_7_L_BIASCM_NMOS} w={MOSFET_17_7_W_BIASCM_NMOS} m={4*MOSFET_17_7_M_BIASCM_NMOS}
I0 net013 GNDA {CURRENT_0_BIAS}
C1 net049 VOUT {CAPACITOR_1}
C0 net050 VOUT {CAPACITOR_0}
.ends leung_nmcf_pin_3
