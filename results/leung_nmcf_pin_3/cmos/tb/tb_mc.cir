.title leung_nmcf_pin_3 cmos LOT MC
.include ../../../../models/cmos.lib
.param mc=1
.include ./params.spice
.include ./dut.spice
.param supply_voltage={VDD}
.param vcm_val={VCM}
Vdd vdd 0 {supply_voltage}
Vss vss 0 0
Vindc opin 0 {vcm_val}
Vin  signal_in 0 dc {vcm_val} ac 1
Lfb opout opout_dc 1T
Cin opout_dc signal_in 1T
X1 vss vdd opout_dc opin opout leung_nmcf_pin_3
Cload1 opout 0 {CLOAD}
.control
set filetype=ascii
set units=degrees
let n=200
let i=1
echo MC_BEGIN
dowhile i <= n
  alterparam mc=1
  reset
  op
  ac dec 20 1 1G
  meas ac dcgain_ find vdb(opout) at=1
  let dcgain = abs(dcgain_)
  meas ac ugf_hz when vdb(opout)=0
  meas ac phase_at_ugf find vp(opout) when vdb(opout)=0
  let pm_deg = phase_at_ugf
  print ugf_hz pm_deg
  let i = i + 1
end
echo MC_END
.endc
.end
