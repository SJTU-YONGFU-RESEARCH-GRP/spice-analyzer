.subckt fan_smc_pin_3 gnda vdda vinn vinp vout
mm11 VOUT net050 VDDA VDDA pmos_rvt w='MOSFET_11_1_W_gmf2_PMOS*1' l='MOSFET_11_1_L_gmf2_PMOS' m='MOSFET_11_1_M_gmf2_PMOS'
mm7 net049 net013 VDDA VDDA pmos_rvt w='MOSFET_0_8_W_BIASCM_PMOS*1' l='MOSFET_0_8_L_BIASCM_PMOS' m='MOSFET_0_8_M_BIASCM_PMOS'
mm10 net043 net050 VDDA VDDA pmos_rvt w='MOSFET_10_1_W_gm2_PMOS*1' l='MOSFET_10_1_L_gm2_PMOS' m='MOSFET_10_1_M_gm2_PMOS'
mm6 net050 VOUTN VDDA VDDA pmos_rvt w='MOSFET_0_8_W_BIASCM_PMOS*1' l='MOSFET_0_8_L_BIASCM_PMOS' m='MOSFET_0_8_M_BIASCM_PMOS'
mm5 VOUTN VOUTN VDDA VDDA pmos_rvt w='MOSFET_0_8_W_BIASCM_PMOS*1' l='MOSFET_0_8_L_BIASCM_PMOS' m='MOSFET_0_8_M_BIASCM_PMOS'
mm9 net063 VINP net31 net31 pmos_rvt w='MOSFET_8_2_W_gm1_PMOS*1' l='MOSFET_8_2_L_gm1_PMOS' m='MOSFET_8_2_M_gm1_PMOS'
mm8 DM_2 VINN net31 net31 pmos_rvt w='MOSFET_8_2_W_gm1_PMOS*1' l='MOSFET_8_2_L_gm1_PMOS' m='MOSFET_8_2_M_gm1_PMOS'
mm4 net31 net013 VDDA VDDA pmos_rvt w='MOSFET_0_8_W_BIASCM_PMOS*1' l='MOSFET_0_8_L_BIASCM_PMOS' m='4*MOSFET_0_8_M_BIASCM_PMOS'
mm3 VB3 net013 VDDA VDDA pmos_rvt w='MOSFET_0_8_W_BIASCM_PMOS*1' l='MOSFET_0_8_L_BIASCM_PMOS' m='MOSFET_0_8_M_BIASCM_PMOS'
mm2 DM_1 net013 VDDA VDDA pmos_rvt w='MOSFET_0_8_W_BIASCM_PMOS*1' l='MOSFET_0_8_L_BIASCM_PMOS' m='MOSFET_0_8_M_BIASCM_PMOS'
mm1 VB4 net013 VDDA VDDA pmos_rvt w='MOSFET_0_8_W_BIASCM_PMOS*1' l='MOSFET_0_8_L_BIASCM_PMOS' m='MOSFET_0_8_M_BIASCM_PMOS'
mm0 net013 net013 VDDA VDDA pmos_rvt w='MOSFET_0_8_W_BIASCM_PMOS*1' l='MOSFET_0_8_L_BIASCM_PMOS' m='MOSFET_0_8_M_BIASCM_PMOS'
mm23 VOUT net049 GNDA GNDA nmos_rvt w='MOSFET_23_1_W_gm3_NMOS*1' l='MOSFET_23_1_L_gm3_NMOS' m='MOSFET_23_1_M_gm3_NMOS'
mm22 net049 net043 GNDA GNDA nmos_rvt w='MOSFET_21_2_W_LOAD2_NMOS*1' l='MOSFET_21_2_L_LOAD2_NMOS' m='MOSFET_21_2_M_LOAD2_NMOS'
mm21 net043 net043 GNDA GNDA nmos_rvt w='MOSFET_21_2_W_LOAD2_NMOS*1' l='MOSFET_21_2_L_LOAD2_NMOS' m='MOSFET_21_2_M_LOAD2_NMOS'
mm19 DM_2 VB4 GNDA GNDA nmos_rvt w='MOSFET_17_7_W_BIASCM_NMOS*1' l='MOSFET_17_7_L_BIASCM_NMOS' m='MOSFET_17_7_M_BIASCM_NMOS*8'
mm15 VOUTN VB3 DM_2 GNDA nmos_rvt w='MOSFET_17_7_W_BIASCM_NMOS*1' l='MOSFET_17_7_L_BIASCM_NMOS' m='MOSFET_17_7_M_BIASCM_NMOS*4'
mm20 net063 VB4 GNDA GNDA nmos_rvt w='MOSFET_17_7_W_BIASCM_NMOS*1' l='MOSFET_17_7_L_BIASCM_NMOS' m='MOSFET_17_7_M_BIASCM_NMOS*8'
mm16 net050 VB3 net063 GNDA nmos_rvt w='MOSFET_17_7_W_BIASCM_NMOS*1' l='MOSFET_17_7_L_BIASCM_NMOS' m='MOSFET_17_7_M_BIASCM_NMOS*4'
mm17 net54 VB4 GNDA GNDA nmos_rvt w='MOSFET_17_7_W_BIASCM_NMOS*1' l='MOSFET_17_7_L_BIASCM_NMOS' m='MOSFET_17_7_M_BIASCM_NMOS*4'
mm14 VB3 VB3 GNDA GNDA nmos_rvt w='MOSFET_17_7_W_BIASCM_NMOS*1' l='MOSFET_17_7_L_BIASCM_NMOS' m='MOSFET_17_7_M_BIASCM_NMOS'
mm12 VB4 VB3 net54 GNDA nmos_rvt w='MOSFET_17_7_W_BIASCM_NMOS*1' l='MOSFET_17_7_L_BIASCM_NMOS' m='MOSFET_17_7_M_BIASCM_NMOS*4'
mm18 net56 VB4 GNDA GNDA nmos_rvt w='MOSFET_17_7_W_BIASCM_NMOS*1' l='MOSFET_17_7_L_BIASCM_NMOS' m='MOSFET_17_7_M_BIASCM_NMOS*4'
mm13 DM_1 VB3 net56 GNDA nmos_rvt w='MOSFET_17_7_W_BIASCM_NMOS*1' l='MOSFET_17_7_L_BIASCM_NMOS' m='MOSFET_17_7_M_BIASCM_NMOS*4'
I0 net013 gnda 'CURRENT_0_BIAS'
C0 net050 vout 'CAPACITOR_0'
.ends fan_smc_pin_3
